// Copyright 2024 Politecnico di Torino.
// Copyright and related rights are licensed under the Solderpad Hardware
// License, Version 2.0 (the "License"); you may not use this file except in
// compliance with the License. You may obtain a copy of the License at
// http://solderpad.org/licenses/SHL-2.0. Unless required by applicable law
// or agreed to in writing, software, hardware and materials distributed under
// this License is distributed on an "AS IS" BASIS, WITHOUT WARRANTIES OR
// CONDITIONS OF ANY KIND, either express or implied. See the License for the
// specific language governing permissions and limitations under the License.
//
// File: control_reg.hjson
// Author(s):
//   Luigi Giuffrida
// Date: 07/11/2024
// Description: Control register description for regtool.py

{
    name: "conv1d_control",
    clock_primary: "clk_i",
    reset_primary: "rst_ni",
    bus_interfaces: [
        {
            protocol: "reg_iface",
            direction: "device",
        },
    ],
    regwidth: "32",
    registers: [
        {
            name: "CONTROL",
            desc: "Accelerator main control and status register",
            fields: [
                {
                    bits: "0",
                    name: "START",
                    desc: '''
                        When this bit is set to 1 by software, the conv1d accelerator should start. Default: 0.
                    ''',
                    swaccess: "rw",
                    hwaccess: "hro",
                    resval: "0",
                }
                {
                    bits: "2",
                    name: "ACK",
                    desc: '''
                        When this bit is set to 1 by software, the conv1d accelerator anck out. Default: 0.
                    ''',
                    swaccess: "rw",
                    hwaccess: "hro",
                    resval: "0",
                }
                // TODO1: add more fields if needed
            ],
            swaccess: "rw",
            hwaccess: "hro",
            resval: "0",
        },
        {
            name: "STATUS",
            desc: "Accelerator status register",
            fields: [
                {
                    bits: "0",
                    name: "RUNNING",
                    desc: '''
                        This bit is set to 1 when the accelerator is running. Default: 0.
                    ''',
                },
                {
                    bits: "1",
                    name: "DONE",
                    desc: '''
                        This bit is set to 1 when the accelerator has finished its computation. Default: 0.
                    ''',
                },
                {
                    bits: "2",
                    name: "OUT_READY",
                    desc: '''
                        This bit is set to 1 when the accellerator puts output data in memory. Default: 0.
                    ''',
                },
                {
                    bits: "3",
                    name: "PAD_READY",
                    desc: '''
                        This bit is set to 1 when the accellerator has completed the padding. Default: 0.
                    ''',
                },
                {
                    bits: "4",
                    name: "S_REQ",
                    desc: '''
                        This bit is set to 1 when the accellerator requests samples. Default: 0.
                    ''',
                },
                {
                    bits: "5",
                    name: "K_REQ",
                    desc: '''
                        This bit is set to 1 when the accellerator requests kernels. Default: 0.
                    ''',
                }
            ],
            swaccess: "rw",
            hwaccess: "hrw",
            resval: "0",
        },

        // TODO: Add more registers if needed

    ],
}
